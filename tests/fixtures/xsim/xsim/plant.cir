* planted ngspice-only default: a cap ic= with no .ic or uic (ngspice drops it, Xyce honours it)
* xsim: true
.include '{{NETLIST}}'
vin in 0 dc 0
r1 in out 1k
c1 out 0 1n ic=1
.tran 1n 5u
.measure tran v0 FIND v(out) AT=10n
.measure tran v1u FIND v(out) AT=1u
.end
