* r2r_dac_analog_emir_tb.cir - the operating point the em_ir gate
* (engine/scripts/check_analog_em_ir.py) reads EM and IR drop from, run on
* the extracted netlist at every corner of the spec's sweep. It fills in the
* pdk path, the extracted netlist and the corner's process, resistor
* section, temperature and supply; no other brace may appear (.format()).
* No .control block: the gate adds `op` and `print all`.
*
* The heaviest DC state: an op at all 256 codes on the extracted ladder
* (typical, 27 C, 3.3 V) draws the most supply current at code 171
* (1010_1011, 121.8 uA) and its complement 85 (121.7 uA), against
* 71 uA at 127 and 41 uA at 255 - alternate bits put the most 2R legs across the
* supply. The pad load is DC-open (100 ohm + 7 pF), so it is left out.
* Instance in netlist/ pin order: dac_code[7..0] vout vdd vss.

.include '{pdk}/libs.tech/ngspice/design.ngspice'
.lib '{pdk}/libs.tech/ngspice/sm141064.spice' {corner}
.lib '{pdk}/libs.tech/ngspice/sm141064.spice' {res_corner}
.include '{pdk}/libs.ref/gf180mcu_fd_sc_mcu7t5v0/spice/gf180mcu_fd_sc_mcu7t5v0.spice'
.include '{extracted}'

.temp {temp_c}

vdd vdd 0 {vdd}
vss vss 0 0

vb7 b7 0 {vdd}
vb6 b6 0 0
vb5 b5 0 {vdd}
vb4 b4 0 0
vb3 b3 0 {vdd}
vb2 b2 0 0
vb1 b1 0 {vdd}
vb0 b0 0 {vdd}

xdut b7 b6 b5 b4 b3 b2 b1 b0 vout vdd vss r2r_dac_analog

.end
