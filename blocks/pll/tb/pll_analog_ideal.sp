* pll_analog_ideal.sp - GENERATED by calibrate_analog.py from
* pll_analog_cal.json (tt_27c, measured on analog/netlist/pll_analog.cir
* with analog/sizing/sizing.yaml). Do not hand-edit; re-run the script.
*
* Behavioural stand-in for the transistor cell inside the cosim bridge:
*  - pump: UP sources Iup(vctrl), DN sinks Idn(vctrl) (measured DC tables,
*    code 00, so the pump's compliance near the rails is the cell's own),
*    scaled by the measured trim ratios; off when pll_en is low
*  - filter: R1 = 2.701e+04 ohm, C1 = 2e-11 F,
*    C2 = 2.143e-12 F, fitted to the cell's own vctrl impedance
*  - VCO: phase integrator (1 F cap, 1 V = 1 cycle) driven by the measured
*    f(vctrl) table, 0 Hz with pll_en low; vco_out = vdd/2*(1+tanh(8 sin))
*    (edges ~2 % of a period)
* Pin order is the cocotbext-ams wrapper's: digital inputs, then outputs,
* then vdd vss. vctrl and the phase node stay internal (x1.vctrl, x1.ph).
.subckt pll_analog_ideal pfd_up pfd_dn pll_en cp_trim0 cp_trim1 vco_out vdd vss
* input conditioning: 20 ps RC so the bridge's stepped sources stay smooth
rin_up pfd_up up_f 1k
cin_up up_f 0 20f
rin_dn pfd_dn dn_f 1k
cin_dn dn_f 0 20f
.param k01=0.245092 k10=0.489505 k11=0.242173
bsc  ksc 0 v = 1 + k01*(v(cp_trim0) > 1.65) + k10*(v(cp_trim1) > 1.65) + k11*(v(cp_trim0) > 1.65)*(v(cp_trim1) > 1.65)
ben  en  0 v = v(pll_en) > 1.65 ? 1 : 0
bup 0 vctrl i = v(en)*v(ksc)*min(max((v(up_f)-0.33)/2.64, 0), 1)*pwl(v(vctrl), 0, 1.90374e-05, 0.05, 1.90373e-05, 0.1, 1.90373e-05, 0.15, 1.90373e-05, 0.2, 1.90372e-05, 0.25, 1.90372e-05, 0.3, 1.90371e-05, 0.35, 1.90371e-05, 0.4, 1.9037e-05, 0.45, 1.9037e-05, 0.5, 1.90369e-05, 0.55, 1.90369e-05, 0.6, 1.90368e-05, 0.65, 1.90367e-05, 0.7, 1.90367e-05, 0.75, 1.90366e-05, 0.8, 1.90365e-05, 0.85, 1.90365e-05, 0.9, 1.90364e-05, 0.95, 1.90363e-05, 1, 1.90362e-05, 1.05, 1.90361e-05, 1.1, 1.9036e-05, 1.15, 1.90359e-05, 1.2, 1.90357e-05, 1.25, 1.90354e-05, 1.3, 1.90349e-05, 1.35, 1.9034e-05, 1.4, 1.90325e-05, 1.45, 1.90302e-05, 1.5, 1.90273e-05, 1.55, 1.90236e-05, 1.6, 1.90193e-05, 1.65, 1.90145e-05, 1.7, 1.90091e-05, 1.75, 1.90032e-05, 1.8, 1.8997e-05, 1.85, 1.89903e-05, 1.9, 1.89833e-05, 1.95, 1.89759e-05, 2, 1.89682e-05, 2.05, 1.89601e-05, 2.1, 1.89517e-05, 2.15, 1.89428e-05, 2.2, 1.89337e-05, 2.25, 1.89241e-05, 2.3, 1.8914e-05, 2.35, 1.89035e-05, 2.4, 1.88924e-05, 2.45, 1.88807e-05, 2.5, 1.88683e-05, 2.55, 1.88551e-05, 2.6, 1.88408e-05, 2.65, 1.88254e-05, 2.7, 1.88083e-05, 2.75, 1.87891e-05, 2.8, 1.87668e-05, 2.85, 1.87395e-05, 2.9, 1.87032e-05, 2.95, 1.86479e-05, 3, 1.85431e-05, 3.05, 1.82771e-05, 3.1, 1.74642e-05, 3.15, 1.54045e-05, 3.2, 1.17392e-05, 3.25, 6.54437e-06, 3.3, -3.36392e-12)
bdn vctrl 0 i = v(en)*v(ksc)*min(max((v(dn_f)-0.33)/2.64, 0), 1)*pwl(v(vctrl), 0, -3.55848e-12, 0.05, 8.05567e-06, 0.1, 1.38242e-05, 0.15, 1.69726e-05, 0.2, 1.7863e-05, 0.25, 1.80329e-05, 0.3, 1.80999e-05, 0.35, 1.81433e-05, 0.4, 1.81775e-05, 0.45, 1.82071e-05, 0.5, 1.82338e-05, 0.55, 1.82585e-05, 0.6, 1.82818e-05, 0.65, 1.8304e-05, 0.7, 1.83254e-05, 0.75, 1.83461e-05, 0.8, 1.83662e-05, 0.85, 1.83858e-05, 0.9, 1.84051e-05, 0.95, 1.84239e-05, 1, 1.84424e-05, 1.05, 1.84606e-05, 1.1, 1.84786e-05, 1.15, 1.84963e-05, 1.2, 1.85137e-05, 1.25, 1.8531e-05, 1.3, 1.8548e-05, 1.35, 1.85648e-05, 1.4, 1.85813e-05, 1.45, 1.85977e-05, 1.5, 1.86137e-05, 1.55, 1.86295e-05, 1.6, 1.8645e-05, 1.65, 1.86602e-05, 1.7, 1.86749e-05, 1.75, 1.8689e-05, 1.8, 1.87026e-05, 1.85, 1.87152e-05, 1.9, 1.87269e-05, 1.95, 1.87371e-05, 2, 1.87457e-05, 2.05, 1.87524e-05, 2.1, 1.8757e-05, 2.15, 1.87597e-05, 2.2, 1.87612e-05, 2.25, 1.87619e-05, 2.3, 1.87624e-05, 2.35, 1.87628e-05, 2.4, 1.87631e-05, 2.45, 1.87633e-05, 2.5, 1.87635e-05, 2.55, 1.87637e-05, 2.6, 1.87639e-05, 2.65, 1.8764e-05, 2.7, 1.87642e-05, 2.75, 1.87643e-05, 2.8, 1.87645e-05, 2.85, 1.87646e-05, 2.9, 1.87647e-05, 2.95, 1.87649e-05, 3, 1.8765e-05, 3.05, 1.87651e-05, 3.1, 1.87652e-05, 3.15, 1.87653e-05, 3.2, 1.87654e-05, 3.25, 1.87655e-05, 3.3, 1.87656e-05)
r1 vctrl vfilt 27013.7
c1 vfilt 0 2.00036e-11
c2 vctrl 0 2.14308e-12
* VCO phase (cycles) on a 1 F cap; gmin keeps it from floating at DC
bph 0 ph i = v(en)*pwl(v(vctrl), 0, 9.18849e+06, 0.1, 9.1885e+06, 0.2, 9.18841e+06, 0.3, 9.18891e+06, 0.4, 9.19523e+06, 0.5, 9.28113e+06, 0.6, 1.00727e+07, 0.7, 1.31878e+07, 0.8, 1.88127e+07, 0.9, 2.60205e+07, 1, 3.42589e+07, 1.1, 4.32587e+07, 1.2, 5.28751e+07, 1.3, 6.30189e+07, 1.4, 7.36263e+07, 1.5, 8.46433e+07, 1.6, 9.60201e+07, 1.7, 1.07724e+08, 1.8, 1.19708e+08, 1.9, 1.31936e+08, 2, 1.44366e+08, 2.1, 1.56955e+08, 2.2, 1.69662e+08, 2.3, 1.82433e+08, 2.4, 1.95203e+08, 2.5, 2.07887e+08, 2.6, 2.2037e+08, 2.7, 2.32428e+08, 2.8, 2.43648e+08, 2.9, 2.52861e+08, 3, 2.57756e+08, 3.1, 2.59371e+08, 3.2, 2.60125e+08, 3.3, 2.60547e+08)
cph ph 0 1
bout vco_out 0 v = 1.65*(1 + tanh(8*sin(6.283185307179586*v(ph))))
.ends pll_analog_ideal
