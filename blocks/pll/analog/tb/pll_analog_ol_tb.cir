* pll_analog_ol_tb.cir - open-loop gain bench, pump + filter + VCO with an
* ideal 1/(P*N) divider (spec.yaml: ol_pm_pn16_nopad_deg,
* ol_pm_pn16_nopad_pvt_deg, ol_pm_pn16_pad5p_deg, ol_fc_pn16_nopad_khz,
* ol_pm_pn8_nopad_deg, ol_pm_pn40_nopad_deg). Written from spec/ only.
* CORNERS: ol_pm_pn16_nopad_pvt_deg (spec rev 2026-10-10 H1, >= 30 deg at
* every corner) is computed and printed at EVERY corner; it has the same
* definition as ol_pm_pn16_nopad_deg (P*N = 16, no pad). The other five are
* scored at tt_27c only (process typical, 27 C, vdd = spec supply 3.3 V), so
* they are printed only there - no placeholder values elsewhere. Icp, Kvco
* and the no-pad ac run happen at every corner (the per-corner cost is the
* tt run's: the same two Kvco transient points); the P*N = 8/40 crossings
* and the 5 pF pad ac run are skipped off tt_27c (tt-only measures).
*
* H(s) = (Icp/2pi) * Z(s) * (2pi Kvco) / (s P N) = Icp Kvco Z(j2pi f) / (j2pi f P N)
* with every factor taken from the DUT itself, cp_trim = 00, pll_en = 1:
*  - Icp   = mean of the UP and DN pump currents at vctrl = vdd/2 (DC op)
*  - Kvco  = (f(vdd-0.3) - f(0.3)) / (vdd-0.6) in Hz/V (mean slope, the same
*            definition and frequency ladder as vco_kvco_mhz_per_v), from
*            transients with lfeed altered to 1 nH (restored to 1 GH for ac);
*            a stalled point reads f = 0, and a Kvco <= 0 prints nothing
*  - Z(s)  = v(vctrl) for a 1 A AC current into vctrl with both pump inputs
*            low: the cell's own R1/C1/C2, V2I gate and pump off-impedance
*            (plus 5 pF for the pad case). vctrl's DC point (vdd/2) is set
*            through a 1 GH feed inductor, an open circuit at 1 kHz and up.
* fc = |H| = 1 crossing; PM = 180 + arg H(fc) = 90 + arg Z(fc) (deg).
* cp_trim stays 00 at every P*N (spec.md's default condition; spec.yaml does
* not name another code for P*N = 40).
* START-UP KICK (as pll_analog_vco_tb.cir): ikick injects 1 uA for 1 ns
* (1 fC, zero at the op) into ring node r1 at t = 1 ns of every Kvco tran, so
* the ring leaves its symmetric balance point, which a noiseless op never
* does in ngspice (it11: stall at vctrl = 0.3 V). ikick is 0 in op/ac.
* sim_timeout_s: 600

.include '{{PDK}}/libs.tech/ngspice/design.spice'
.lib '{{PDK}}/libs.tech/ngspice/sm141064.spice' {{CORNER}}
.lib '{{PDK}}/libs.tech/ngspice/sm141064.spice' {{RES_CORNER}}
.lib '{{PDK}}/libs.tech/ngspice/sm141064.spice' {{MIM_CORNER}}
.include '{{NETLIST}}'
{{SIZING}}

.temp {{TEMP_C}}
.param vddp={{VDD}}
.param tempp={{TEMP_C}}
.param p_typical=1 p_ss=2 p_ff=3
.csparam procn={p_{{CORNER}}}
.csparam tempc={tempp}
.csparam vddp={vddp}
.csparam vmid={vddp/2}
.csparam vhi={vddp-0.3}

vdd_src  vdd      0 {vddp}
vss_src  vss      0 0
ven      pll_en   0 {vddp}
vup      pfd_up   0 0
vdn      pfd_dn   0 0
vt0      cp_trim0 0 0
vt1      cp_trim1 0 0
vvc      vfeed    0 {vddp/2}
lfeed    vfeed    vctrl 1e9
cpad     vctrl    0 1e-18
iac      0        vctrl dc 0 ac 1
cload    vco_out  0 15f
xdut vco_out pfd_up pfd_dn pll_en cp_trim0 cp_trim1 vctrl bias_ref vdd vss pll_analog
ikick    0        xdut.r1 pulse(0 1u 1n 50p 50p 1n 1)

.control
set noaskquit
set istt = "0"
if (procn eq 1) and (tempc eq 27) and (abs(vddp - 3.3) lt 0.01)
  set istt = "1"
end
set okall = "0"
* every corner: Icp, Kvco and the no-pad ac run (ol_pm_pn16_nopad_pvt_deg)
* --- Icp at vdd/2, code 00
alter vup dc = $&vddp
op
let x = i(vvc)
set iup = "$&x"
alter vup dc = 0
alter vdn dc = $&vddp
op
let x = (-i(vvc) + $iup)/2
set icp = "$&x"
alter vdn dc = 0
* --- Kvco (mean slope over the tuning range), same frequency ladder as
* pll_analog_vco_tb.cir. lfeed is dropped to 1 nH for the transients (a
* 1 GH series inductor makes every tran step ill-conditioned: wo-2 saw a
* run stall at 15 time points) and restored to 1 GH before the ac runs.
alter lfeed = 1e-9
set fl = "0"
set fh = "0"
set first = "1"
foreach vc 0.3 $&vhi
  alter vvc dc = $vc
  set gotf = "0"
  set fks = "0"
  foreach st 0 1
    if $gotf eq 0
      if $st eq 0
        set tsx = "20p"
        set tex = "25n"
        set tdx = "4n"
      end
      if $st eq 1
        set tsx = "250p"
        set tex = "400n"
        set tdx = "20n"
      end
      tran $tsx $tex 0 $tsx
      let nx = length(time)
      let nx1 = nx - 1
      let nx2 = nx - 2
      let hv = (v(vco_out) gt vmid)
      let late = time[1,$&nx1] gt $tdx
      let nrise = mean(((hv[1,$&nx1] - hv[0,$&nx2]) gt 0.5) and late)*length(late)
      if (nrise ge 6) or ($st eq 1)
        set gotf = "1"
        let np = nrise - 1
        if np gt 5
          let np = 5
        end
        if np ge 1
          let nr = np + 1
          meas tran ta when v(vco_out)=$&vmid rise=1 td=$tdx
          meas tran tb when v(vco_out)=$&vmid rise=$&nr td=$tdx
          let x = np/(tb - ta)
          set fks = "$&x"
        end
      end
      destroy $curplot
    end
  end
  if $first eq 1
    set fl = "$fks"
    set first = "0"
  else
    set fh = "$fks"
  end
end
alter lfeed = 1e9
let x = ($fh - $fl)/(vhi - 0.3)
set kv = "$&x"
if x gt 0
  alter vvc dc = $&vmid
  * --- Z(s) at vctrl, no pad
  ac dec 50 1k 100meg
  let zp = 180/pi*ph(v(vctrl))
  let fr = real(frequency)
  let g = $icp * $kv * mag(v(vctrl)) / (2*pi*fr)
  let h16 = g/16
  * fc16 stays 0 if |H| never crosses 1 (a failed meas leaves it): no print
  let fc16 = 0
  meas ac fc16 when h16=1 fall=1
  if fc16 gt 0
    meas ac pz16 find zp at=$&fc16
    let x = 90 + pz16
    set pm16 = "$&x"
    set okall = "1"
  end
  * --- tt_27c only: P*N = 8 / 40 crossings, fc, and the 5 pF pad case
  if ($okall eq 1) and ($istt eq 1)
    let h8 = g/8
    let h40 = g/40
    meas ac fc8 when h8=1 fall=1
    meas ac fc40 when h40=1 fall=1
    meas ac pz8 find zp at=$&fc8
    meas ac pz40 find zp at=$&fc40
    let x = 90 + pz8
    set pm8 = "$&x"
    let x = 90 + pz40
    set pm40 = "$&x"
    let x = fc16/1e3
    set fc16k = "$&x"
    alter cpad = 5e-12
    ac dec 50 1k 100meg
    let zp = 180/pi*ph(v(vctrl))
    let fr = real(frequency)
    let h16 = $icp * $kv * mag(v(vctrl)) / (2*pi*fr*16)
    meas ac fc16p when h16=1 fall=1
    meas ac pz16p find zp at=$&fc16p
    let x = 90 + pz16p
    set pm16p = "$&x"
  end
end
echo
echo "  Measurements for AC Analysis (pll_analog_ol_tb, computed in .control)"
if $okall eq 1
  echo "ol_pm_pn16_nopad_pvt_deg = $pm16"
end
if ($okall eq 1) and ($istt eq 1)
  echo "ol_pm_pn16_nopad_deg = $pm16"
  echo "ol_pm_pn16_pad5p_deg = $pm16p"
  echo "ol_fc_pn16_nopad_khz = $fc16k"
  echo "ol_pm_pn8_nopad_deg = $pm8"
  echo "ol_pm_pn40_nopad_deg = $pm40"
end
echo
.endc

.end
