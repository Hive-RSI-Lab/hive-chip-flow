* mirror_emir_tb.cir - the operating point the em_ir gate
* (engine/scripts/check_analog_em_ir.py) reads EM and IR drop from, run on
* the extracted netlist at every corner of the spec's sweep. The gate fills
* in the pdk path, the extracted netlist and the corner's process,
* temperature and supply; no .control block, the gate adds `op` and
* `print all`.
*
* The heaviest DC state is the only one the mirror has: the same bias as
* tb/mirror_tb.cir and the pex bench (10uA into iref_node, iout loaded by
* 20k to vdd), so vss carries the reference and the mirrored current,
* about 30uA. The pex bench's AC probe is DC-open and left out.
.include '{pdk}/libs.tech/ngspice/design.spice'
.lib '{pdk}/libs.tech/ngspice/sm141064.spice' {corner}
.include '{extracted}'
.temp {temp_c}

vdd vdd 0 dc {vdd}
iref_src vdd iref_node dc 10u
rload vdd iout 20k
xdut iref_node iout vdd 0 current_mirror
.end
