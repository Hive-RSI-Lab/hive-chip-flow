* mirror_tb.cir - the current_mirror bench (docs/design.md 1.3/5's
* .bounds.json sidecar shape, "### M8."). {{PDK}}/{{CORNER}}/{{TEMP_C}}/
* {{VDD}}/{{NETLIST}}/{{SIZING}} are sim_run.py's own deck placeholders
* (engine/lib/simlib.py:materialize) - never edited by hand into literal
* values, filled in fresh per corner/sizing run.
*
* Operating-point start, no `uic`: docs/spikes/dcosim.md found a real
* gf180 convergence failure under a uic cold start on active devices; this
* bench's own `.tran` (with no `uic`) computes a proper DC operating point
* first, which is what actually converges (confirmed empirically while
* building this gate - see engine/lib/simlib.py's own module docstring for
* the case where skipping that step let ngspice "succeed" on a floating
* node with singular-matrix warnings and a meaningless answer).
.include '{{PDK}}/libs.tech/ngspice/design.spice'
.lib '{{PDK}}/libs.tech/ngspice/sm141064.spice' {{CORNER}}
.temp {{TEMP_C}}
.include '{{NETLIST}}'
{{SIZING}}

vdd_src  vdd 0 {{VDD}}
iref_src vdd iref_node dc 10e-6
xmirror  iref_node iout vdd 0 current_mirror
* a 0V "ammeter": the current the mirror pulls from vdd into iout is
* exactly the current through this source (i(vload)).
vload    vdd iout 0

.tran 0.1n 5n
.measure tran iout_raw FIND i(vload) AT=5n

.control
run
.endc
.end
