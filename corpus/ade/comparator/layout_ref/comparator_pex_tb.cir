* comparator_pex_tb.cir - the post-layout bench for the comparator, at each
* pex_sim corner (docs/design.md 1.5's ade pex_sim row). It runs on the magic-
* extracted, parasitic-annotated netlist of this run's own GDS;
* check_pex_sim.py fills in its tokens, never a path typed by hand.
*
* tb/comparator_tb.cir's stimulus with a 10mV input step, not 1mV: clk
* rises at 5n with inp 10mV above inn, the inputs swap during the reset at
* 11n, clk rises again at 15n. Every fF and ohm the layout hangs on
* outp/outn/dp/dn slows the latch, so the decision delay is what this bench
* bounds; the two decisions and the reset level confirm the layout still
* works as a comparator.
*
* Why 10mV. The latch turns any capacitance difference between outp and
* outn into input offset, at roughly 30uV per 0.001fF on this extraction:
* 0.045fF more on outn to ground already decided both 1mV inputs the same
* way, and the reference layout, mirrored device for device, still
* extracts about 0.1fF of difference (the one place the outputs cross),
* i.e. 2 to 4mV of offset. A 1mV post-layout step is therefore a bench no
* real layout passes, and even with the two outputs matched exactly the
* 1mV decision took 0.63ns, past the 0.5ns bound. At 10mV the reference
* decides both ways with tdelay 0.41ns; the bounds are unchanged.
.include '{pdk}/libs.tech/ngspice/design.spice'
.lib '{pdk}/libs.tech/ngspice/sm141064.spice' {corner}
.include '{extracted}'
.temp {temp_c}

.param vcm={vdd}/2
vdd vdd 0 dc {vdd}
vclk clk 0 PULSE(0 {vdd} 5n 50p 50p 4.95n 10n)
vinp inp 0 PWL(0 {{vcm+5m}} 11n {{vcm+5m}} 11.1n {{vcm-5m}} 30n {{vcm-5m}})
vinn inn 0 PWL(0 {{vcm-5m}} 11n {{vcm-5m}} 11.1n {{vcm+5m}} 30n {{vcm+5m}})
xdut inp inn clk outp outn vdd 0 strongarm_comparator
cloadp outp 0 10f
cloadn outn 0 10f
ediff vd 0 outp outn 1

.control
tran 10p 20n
meas tran vdiff_pos find v(vd) at=9.5n
meas tran vdiff_neg find v(vd) at=19.5n
let vth = {vdd}*1.4/3.3
meas tran tdelay trig v(clk) val=$&vth rise=1 targ v(outn) val=$&vth fall=1
* a trig/targ meas line carries "targ= trig=" after its value, which
* check_pex_sim.py does not read; print the vector on a line of its own
print tdelay
meas tran vreset find v(outn) at=14.5n
.endc
.end
