* ota.cir - the two_stage_miller_ota subcircuit (skills/ade/reference/
* topologies/two_stage_miller_ota.sp, this rung's own sizing). A subckt
* LIBRARY, never directly runnable: the tb/ benches put it in unity-gain
* feedback (out tied to inn) and drive it.
*
* Stage 1: NMOS pair xm1/xm2 on the tail xmt, PMOS mirror load xm3/xm4.
* Stage 2: PMOS common source xm6 with the NMOS sink xm7. xmb is the bias
* diode: the bench forces a current into the ibias pin and xmt/xm7 mirror
* it. xcc is the Miller compensation cap from the first stage's output d2
* to out, a MIM cap (cap_mim_2f0_m4m5_noshield, 2 fF/um^2, the MIM the
* benches' {{MIM_CORNER}} section corners), in series with xrz, a nulling
* resistor (ppolyf_u, about 350 ohm/sq, the benches' {{RES_CORNER}} section)
* from the cap's bottom plate dz to out. xrz moves the Miller zero from the
* right half plane into the left, where it cancels the pole the out pin's
* Tiny Tapeout pad (500 ohm, 5 pF) adds (#297, spec.md "Values chosen").
* inp rising pulls d2 down and out up: inp is the non-inverting input.
*
* Sizing: every W/L is a GLOBAL .param named in sizing/sizing.yaml, with the
* defaults below equal to that file's values (the bench's {{SIZING}} line
* comes after this file and wins). Device lines use bare names (w=w_in, not
* w={w_in}) so bench_strength's size mutant ("*2") is honoured.
* xm6 and xm7 are split into parallel units (ten of w_2/10, two of w_s/2),
* as the layout splits them: GF180's 3.3 V models are binned only up to
* W = 100 um and sizing.yaml lets w_2 and w_s reach 200 um, where a single
* device has no model at all. LVS combines parallel units, so it compares
* the same total width.
.param w_b=3.945e-6 w_t=7.89e-6 l_b=1e-6
.param w_in=10e-6 l_in=1e-6
.param w_ld=4.5e-6 l_ld=1e-6
.param w_2=89.35e-6 w_s=78.9e-6 l_2=1e-6
.param cc_w=26e-6 rz_w=2e-6 rz_l=25.5e-6
.subckt two_stage_miller_ota inp inn out vdd vss ibias
xmb  ibias ibias vss  vss nfet_03v3 w=w_b  l=l_b
xmt  tail  ibias vss  vss nfet_03v3 w=w_t  l=l_b
xm1  d1    inn   tail vss nfet_03v3 w=w_in l=l_in
xm2  d2    inp   tail vss nfet_03v3 w=w_in l=l_in
xm3  d1    d1    vdd  vdd pfet_03v3 w=w_ld l=l_ld
xm4  d2    d1    vdd  vdd pfet_03v3 w=w_ld l=l_ld
xm6  out   d2    vdd  vdd pfet_03v3 w={w_2/10} l=l_2 m=10
xm7  out   ibias vss  vss nfet_03v3 w={w_s/2} l=l_b m=2
xrz  dz    out   vss  ppolyf_u r_width=rz_w r_length=rz_l
xcc  d2    dz    cap_mim_2f0_m4m5_noshield c_width=cc_w c_length=cc_w
* The layout (layout/gen_ota.py) draws each transistor as unit devices in
* three matched rows, a dummy at each row's ends, one unit wide: w_b in the
* bias row, half of w_in in the pair's, half of w_ld in the load's. The
* dummies are drawn, so they are in the schematic too, every terminal on
* their row's rail, and they follow the sizing as the units do.
xmdum1 vss vss vss vss nfet_03v3 w=w_b l=l_b
xmdum2 vss vss vss vss nfet_03v3 w=w_b l=l_b
xmdum3 vss vss vss vss nfet_03v3 w={w_in/2} l=l_in
xmdum4 vss vss vss vss nfet_03v3 w={w_in/2} l=l_in
xmdum5 vdd vdd vdd vdd pfet_03v3 w={w_ld/2} l=l_ld
xmdum6 vdd vdd vdd vdd pfet_03v3 w={w_ld/2} l=l_ld
.ends two_stage_miller_ota
