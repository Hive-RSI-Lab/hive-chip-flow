* ota_psrr_tb.cir - supply rejection of the two_stage_miller_ota as a
* unity-gain buffer (spec.md, Requirement), from skills/ade/templates/
* psrr_tb.cir. 1 V AC rides on vdd only; the input is a quiet DC source.
* PSRR = -20 log10 |v(out)/v(vdd)|: psrr_dc_db at f_dc, psrr_at_f_db at
* f_psrr (spec.md states both frequencies).
.include '{{PDK}}/libs.tech/ngspice/design.spice'
.lib '{{PDK}}/libs.tech/ngspice/sm141064.spice' {{CORNER}}
.lib '{{PDK}}/libs.tech/ngspice/sm141064.spice' {{MIM_CORNER}}
.temp {{TEMP_C}}
.include '{{NETLIST}}'
{{SIZING}}

.param vddp={{VDD}} vcm='vddp/2' ib=10u cl=2p
.param f_dc=10 f_psrr=100k
.csparam f_dc={f_dc}
.csparam f_psrr={f_psrr}
vdd_src vdd 0 dc {vddp} ac 1
vss_src vss 0 0
vin inp 0 dc {vcm}
ibias_src 0 ibias dc {ib}
* --- DUT BEGIN
xdut inp out out vdd vss ibias two_stage_miller_ota
cload out 0 {cl}
* --- DUT END

.control
set noaskquit
ac dec 20 1 1g
let psrr = -db(v(out)/v(vdd))
meas ac psrr_dc_v find psrr at=$&f_dc
meas ac psrr_f_v find psrr at=$&f_psrr
echo
echo "  Measurements for AC Analysis (ota_psrr_tb, computed in .control)"
echo "psrr_dc_db = $&psrr_dc_v"
echo "psrr_at_f_db = $&psrr_f_v"
echo
.endc
.end
