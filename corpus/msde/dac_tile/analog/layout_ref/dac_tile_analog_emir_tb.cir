* dac_tile_analog_emir_tb.cir - the operating point the em_ir gate (
* engine/scripts/check_analog_em_ir.py) reads EM and IR drop from, run on
* the extracted netlist at every corner of the spec's sweep. The gate fills
* in the pdk path, the extracted netlist and the corner's process,
* temperature and supply; no .control block, the gate adds `op` and
* `print all`.
*
* The heaviest DC state: an op on the schematic (typical, 27 C, 3.3 V) at
* all four codes draws the most supply current at code 10 (bmsb high,
* blsb low: 242 uA), against 216 uA at 00, 155 uA at 01 and under 1 nA at
* 11. The bits only drive switch gates, so they are ideal sources.
.include '{pdk}/libs.tech/ngspice/design.spice'
.lib '{pdk}/libs.tech/ngspice/sm141064.spice' {corner}
.lib '{pdk}/libs.tech/ngspice/sm141064.spice' {res_corner}
.include '{extracted}'
.temp {temp_c}

vdd vdd 0 dc {vdd}
vbmsb bmsb 0 dc {vdd}
vblsb blsb 0 dc 0
xdut bmsb blsb vout vdd 0 dac_tile_analog
.end
