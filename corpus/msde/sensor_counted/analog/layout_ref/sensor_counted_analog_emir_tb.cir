* sensor_counted_analog_emir_tb.cir - the operating point the em_ir gate (
* engine/scripts/check_analog_em_ir.py) reads EM and IR drop from, run on
* the extracted netlist at every corner of the spec's sweep. The gate fills
* in the pdk path, the extracted netlist and the corner's process,
* temperature and supply; no .control block, the gate adds `op` and
* `print all`.
*
* The heaviest DC state: an op on the schematic (typical, 27 C, 3.3 V) draws
* 59 uA with osc_en high - the ring's operating point has every stage at its
* switching point, each conducting through both devices - against under
* 1 nA with osc_en low. The pex bench's 20f load is DC-open, left out.
.include '{pdk}/libs.tech/ngspice/design.spice'
.lib '{pdk}/libs.tech/ngspice/sm141064.spice' {corner}
.include '{extracted}'
.temp {temp_c}

vdd_src vdd 0 dc {vdd}
ven_src osc_en 0 dc {vdd}
xdut osc_en osc_out vdd 0 sensor_counted_analog
.end
